* Mirrored Howland current pump - load sweep (current-source check)
* R8/R13 = 1k (the value that gives ~1 mA p-p at 1 V p-p excitation),
* bridge network stays 47k. Sweep the external load: a current pump's
* output current should stay flat as RL changes.
*
* Run:  wine LTspice.exe -b howland_loadsweep.cir

.include ADTL082.lib

.param RB   = 47k
.param RS   = 1k
.param RL   = 1k
.param VAMP = 0.5

VCC VCC 0 5
VEE VEE 0 -5
VIN IN  0 DC 0 AC 1 SINE(0 {VAMP} 50k)

R6  IN    A_INM {RB}
R7  A_INM A_OUT {RB}
R9  DRV_P A_INP {RB}
R10 A_INP 0     {RB}
R8  A_OUT A_C3  {RS}
C3  A_C3  DRV_P 0.1u
XU5A A_INP A_INM VCC VEE A_OUT ADTL082

R11 B_INM 0     {RB}
R12 B_INM B_OUT {RB}
R14 DRV_M B_INP {RB}
R15 B_INP IN    {RB}
R13 B_OUT B_C2  {RS}
C2  B_C2  DRV_M 0.1u
XU5B B_INP B_INM VCC VEE B_OUT ADTL082

RL  DRV_P DRV_M {RL}

.step param RL list 100 470 1k 2.2k 4.7k 10k
.tran 0 400u 0 0.02u
.meas tran iL_pp  PP I(RL)           FROM 300u TO 400u
.meas tran vL_pp  PP V(DRV_P,DRV_M)  FROM 300u TO 400u
.meas tran va_max MAX V(A_OUT)        FROM 300u TO 400u
.meas tran va_min MIN V(A_OUT)        FROM 300u TO 400u
.meas tran vb_max MAX V(B_OUT)        FROM 300u TO 400u
.meas tran vb_min MIN V(B_OUT)        FROM 300u TO 400u
.end
